; Generate a no-GUI Allegro board for static-shape spacing against other etch objects.

(setq soeLog (outfile "out/generate_shape_other_etch_cases_trace.txt" "w"))
(fprintf soeLog "loaded script\n")

(defun soe_point (x y)
  x:y
)

(defun soe_text (txt x y)
  (let ((ori nil))
    (setq ori (make_axlTextOrientation ?textBlock "1" ?rotation 0.0 ?mirrored nil ?justify "left"))
    (axlDBCreateText txt (soe_point x y) ori "BOARD GEOMETRY/SILKSCREEN_TOP" nil)
  )
)

(defun soe_rect (x1 y1 x2 y2 layer fill net)
  (car (axlDBCreateRectangle (list (soe_point x1 y1) (soe_point x2 y2)) fill layer net))
)

(defun soe_make_nets ()
  (let ((shape_net nil) (other_net nil) (via_net nil) (shape_class nil) (other_class nil) (via_class nil))
    (setq shape_net (axlDBCreateNet "SOE_SHAPE"))
    (setq other_net (axlDBCreateNet "SOE_OTHER"))
    (setq via_net (axlDBCreateNet "SOE_VIA"))
    (setq shape_class (axlNetClassCreate "SOE_SHAPE_CLASS" 'spacing))
    (setq other_class (axlNetClassCreate "SOE_OTHER_CLASS" 'spacing))
    (setq via_class (axlNetClassCreate "SOE_VIA_CLASS" 'spacing))
    (when shape_class (axlNetClassAdd shape_class shape_net))
    (when other_class (axlNetClassAdd other_class other_net))
    (when via_class (axlNetClassAdd via_class via_net))
  )
)

(defun soe_make_cset (name shape_shape_value via_shape_value)
  (cond
    ((equal name "DEFAULT")
     (axlCNSSetSpacing "" "TOP" 'shape_shape shape_shape_value)
     (axlCNSSetSpacing "" "TOP" 'via_shape via_shape_value))
    (t
     (axlCNSCreate 'spacing name nil)
     (axlCNSSetSpacing name "TOP" 'shape_shape shape_shape_value)
     (axlCNSSetSpacing name "TOP" 'via_shape via_shape_value))
  )
)

(defun soe_bind_region_shape_shape (region_name cset_name)
  (axlCnsClassTableCreate "SOE_SHAPE_CLASS" "SOE_OTHER_CLASS" region_name 'spacing cset_name)
)

(defun soe_bind_region_via_shape (region_name cset_name)
  (axlCnsClassTableCreate "SOE_SHAPE_CLASS" "SOE_VIA_CLASS" region_name 'spacing cset_name)
)

(defun soe_region_rect (name cset x1 y1 x2 y2 bind_mode)
  (let ((reg nil) (rshape nil))
    (setq reg (axlRegionCreate name))
    (setq rshape (soe_rect x1 y1 x2 y2 "CONSTRAINT REGION/OUTER_LAYERS" nil nil))
    (axlRegionAdd reg rshape)
    (cond
      ((equal bind_mode "shape_shape") (soe_bind_region_shape_shape name cset))
      ((equal bind_mode "via_shape") (soe_bind_region_via_shape name cset))
    )
    rshape
  )
)

(defun soe_create_via (x y)
  (let ((v nil))
    (setq v (axlDBCreateVia "via" (soe_point x y) "SOE_VIA"))
    (when (null v) (setq v (axlDBCreateVia "VIA" (soe_point x y) "SOE_VIA")))
    (when (null v) (setq v (axlDBCreateVia "pad1" (soe_point x y) "SOE_VIA")))
    (when v (car v))
  )
)

(defun soe_case_shape_shape (idx case_id rel expected)
  (let ((x nil) (y nil) (r1 nil) (cset nil))
    (setq x (plus 250 (times idx 760)))
    (setq y 500)
    (setq r1 (strcat case_id "_R1"))
    (setq cset (strcat case_id "_R1_CSET"))
    (soe_make_cset cset 21.0 21.0)
    ; Main static shape on SOE_SHAPE and another static shape on SOE_OTHER, 10 mil gap.
    (soe_rect (plus x 300) (plus y 220) (plus x 420) (plus y 340) "ETCH/TOP" t "SOE_SHAPE")
    (soe_rect (plus x 170) (plus y 220) (plus x 290) (plus y 340) "ETCH/TOP" t "SOE_OTHER")
    (cond
      ((equal rel "main_shape_side_inside")
       (soe_region_rect r1 cset (plus x 295) (plus y 250) (plus x 340) (plus y 315) "shape_shape"))
      ((equal rel "other_shape_side_inside")
       (soe_region_rect r1 cset (plus x 250) (plus y 250) (plus x 295) (plus y 315) "shape_shape"))
      ((equal rel "outside")
       (soe_region_rect r1 cset (plus x 430) (plus y 250) (plus x 480) (plus y 315) "shape_shape"))
      ((equal rel "boundary")
       (soe_region_rect r1 cset (plus x 300) (plus y 250) (plus x 350) (plus y 315) "shape_shape"))
    )
    (soe_text (strcat case_id " shape-shape") x (plus y 420))
    (soe_text (strcat "rel=" rel) x (plus y 395))
    (soe_text (strcat "expect=" expected) x (plus y 370))
  )
)

(defun soe_case_via_shape (idx case_id rel expected)
  (let ((x nil) (y nil) (r1 nil) (cset nil) (via nil))
    (setq x (plus 250 (times idx 760)))
    (setq y 1200)
    (setq r1 (strcat case_id "_R1"))
    (setq cset (strcat case_id "_R1_CSET"))
    (soe_make_cset cset 21.0 21.0)
    (soe_rect (plus x 300) (plus y 220) (plus x 420) (plus y 340) "ETCH/TOP" t "SOE_SHAPE")
    (setq via (soe_create_via (plus x 290) (plus y 280)))
    (cond
      ((equal rel "shape_side_inside")
       (soe_region_rect r1 cset (plus x 295) (plus y 250) (plus x 340) (plus y 315) "via_shape"))
      ((equal rel "via_side_inside")
       (soe_region_rect r1 cset (plus x 260) (plus y 250) (plus x 295) (plus y 315) "via_shape"))
      ((equal rel "outside")
       (soe_region_rect r1 cset (plus x 430) (plus y 250) (plus x 480) (plus y 315) "via_shape"))
      ((equal rel "boundary")
       (soe_region_rect r1 cset (plus x 300) (plus y 250) (plus x 350) (plus y 315) "via_shape"))
    )
    (soe_text (strcat case_id " via-shape") x (plus y 420))
    (soe_text (strcat "rel=" rel) x (plus y 395))
    (soe_text (strcat "expect=" expected) x (plus y 370))
    (when (null via) (soe_text "VIA CREATE FAILED" x (plus y 345)))
  )
)

(defun soe_generate ()
  (fprintf soeLog "enter generate\n")
  (soe_make_nets)
  (soe_make_cset "DEFAULT" 11.0 11.0)
  (axlCNSSpacingModeSet 'all 'off)
  (axlCNSSpacingModeSet 'shape_shape 'on)
  (axlCNSSpacingModeSet 'via_shape 'on)
  (soe_rect 100 100 3450 1900 "BOARD GEOMETRY/OUTLINE" nil nil)
  (soe_text "Other etch object region DRC cases" 120 1950)
  (soe_case_shape_shape 0 "OE001" "main_shape_side_inside" "R1?")
  (soe_case_shape_shape 1 "OE002" "other_shape_side_inside" "R1 or DEFAULT?")
  (soe_case_shape_shape 2 "OE003" "outside" "DEFAULT")
  (soe_case_shape_shape 3 "OE004" "boundary" "R1?")
  (soe_case_via_shape 0 "OE005" "shape_side_inside" "R1?")
  (soe_case_via_shape 1 "OE006" "via_side_inside" "R1 or DEFAULT?")
  (soe_case_via_shape 2 "OE007" "outside" "DEFAULT")
  (soe_case_via_shape 3 "OE008" "boundary" "R1?")
  (axlSaveDesign ?design "out/shape_other_etch_result_cases.brd" ?mode "nocheck" ?noConfirm t)
  (fprintf soeLog "saved board\n")
  (close soeLog)
  (axlOSExit 0)
)

(soe_generate)
