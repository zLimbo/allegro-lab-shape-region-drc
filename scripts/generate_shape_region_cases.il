; Generate a no-GUI Allegro board containing shape/line/region DRC cases.
; The board is a visual and DRC scaffold derived from matrix/shape_region_case_matrix.csv.

(setq srdLog (outfile "out/generate_shape_region_cases_trace.txt" "w"))
(fprintf srdLog "loaded script\n")

(defun srd_point (x y)
  x:y
)

(defun srd_text (txt x y)
  (let ((ori nil))
    (setq ori (make_axlTextOrientation ?textBlock "1" ?rotation 0.0 ?mirrored nil ?justify "left"))
    (axlDBCreateText txt (srd_point x y) ori "BOARD GEOMETRY/SILKSCREEN_TOP" nil)
  )
)

(defun srd_create_net_and_classes ()
  (let ((net_shape nil) (net_line nil) (cls_shape nil) (cls_line nil))
    (setq net_shape (axlDBCreateNet "SRD_SHAPE"))
    (setq net_line (axlDBCreateNet "SRD_LINE"))
    (setq cls_shape (axlNetClassCreate "SRD_SHAPE_CLASS" 'spacing))
    (setq cls_line (axlNetClassCreate "SRD_LINE_CLASS" 'spacing))
    (when cls_shape (axlNetClassAdd cls_shape net_shape))
    (when cls_line (axlNetClassAdd cls_line net_line))
  )
)

(defun srd_create_spacing_cset (name value)
  (cond
    ((equal name "DEFAULT")
     (axlCNSSetSpacing "" "TOP" 'line_shape value)
     (axlCNSSetSpacing "" "ETCH/TOP" 'line_shape value))
    (t
     (axlCNSCreate 'spacing name nil)
     (axlCNSSetSpacing name "TOP" 'line_shape value)
     (axlCNSSetSpacing name "ETCH/TOP" 'line_shape value))
  )
)

(defun srd_bind_region (region_name cset_name)
  (axlCnsClassTableCreate "SRD_SHAPE_CLASS" "SRD_LINE_CLASS" region_name 'spacing cset_name)
)

(defun srd_rect (x1 y1 x2 y2 layer fill net)
  (car (axlDBCreateRectangle (list (srd_point x1 y1) (srd_point x2 y2)) fill layer net))
)

(defun srd_path (x1 y1 x2 y2 width layer net)
  (car (car (axlDBCreatePath (axlPathStart (list (srd_point x1 y1) (srd_point x2 y2)) width) layer net)))
)

(defun srd_region_rect (name cset x1 y1 x2 y2)
  (let ((reg nil) (rshape nil))
    (setq reg (axlRegionCreate name))
    (setq rshape (srd_rect x1 y1 x2 y2 "CONSTRAINT REGION/OUTER_LAYERS" nil nil))
    (axlRegionAdd reg rshape)
    (srd_bind_region name cset)
    rshape
  )
)

(defun srd_case_regions (case_id rel x y r1_value r2_value)
  (let ((r1 nil) (r2 nil) (r3 nil))
    (setq r1 (strcat case_id "_R1"))
    (setq r2 (strcat case_id "_R2"))
    (setq r3 (strcat case_id "_R3"))
    (srd_create_spacing_cset (strcat case_id "_R1_CSET") r1_value)
    (srd_create_spacing_cset (strcat case_id "_R2_CSET") r2_value)
    (cond
      ((equal rel "inside")
       (srd_region_rect r1 (strcat case_id "_R1_CSET") (plus x 295) (plus y 250) (plus x 340) (plus y 315)))
      ((equal rel "outside")
       (srd_region_rect r1 (strcat case_id "_R1_CSET") (plus x 318) (plus y 250) (plus x 390) (plus y 315)))
      ((equal rel "on_edge")
       (srd_region_rect r1 (strcat case_id "_R1_CSET") (plus x 300) (plus y 250) (plus x 345) (plus y 315)))
      ((equal rel "on_vertex")
       (srd_region_rect r1 (strcat case_id "_R1_CSET") (plus x 300) (plus y 280) (plus x 350) (plus y 330)))
      ((equal rel "line_inside_shape_outside")
       (srd_region_rect r1 (strcat case_id "_R1_CSET") (plus x 276) (plus y 248) (plus x 296) (plus y 315)))
      ((equal rel "shape_inside_line_outside")
       (srd_region_rect r1 (strcat case_id "_R1_CSET") (plus x 295) (plus y 248) (plus x 338) (plus y 315)))
      ((equal rel "upper_band")
       (srd_region_rect r1 (strcat case_id "_R1_CSET") (plus x 292) (plus y 315) (plus x 345) (plus y 372)))
      ((equal rel "lower_band")
       (srd_region_rect r1 (strcat case_id "_R1_CSET") (plus x 292) (plus y 205) (plus x 345) (plus y 260)))
      ((equal rel "middle_band")
       (srd_region_rect r1 (strcat case_id "_R1_CSET") (plus x 292) (plus y 260) (plus x 345) (plus y 315)))
      ((equal rel "inside_both")
       (srd_region_rect r1 (strcat case_id "_R1_CSET") (plus x 288) (plus y 245) (plus x 325) (plus y 315))
       (srd_region_rect r2 (strcat case_id "_R2_CSET") (plus x 295) (plus y 235) (plus x 360) (plus y 305)))
      ((equal rel "touch_edge")
       (srd_region_rect r1 (strcat case_id "_R1_CSET") (plus x 260) (plus y 245) (plus x 300) (plus y 315))
       (srd_region_rect r2 (strcat case_id "_R2_CSET") (plus x 300) (plus y 245) (plus x 350) (plus y 315)))
      ((equal rel "touch_vertex")
       (srd_region_rect r1 (strcat case_id "_R1_CSET") (plus x 260) (plus y 240) (plus x 300) (plus y 280))
       (srd_region_rect r2 (strcat case_id "_R2_CSET") (plus x 300) (plus y 280) (plus x 350) (plus y 330)))
      ((equal rel "inside_R1_boundary_R2")
       (srd_region_rect r1 (strcat case_id "_R1_CSET") (plus x 292) (plus y 250) (plus x 340) (plus y 315))
       (srd_region_rect r2 (strcat case_id "_R2_CSET") (plus x 300) (plus y 245) (plus x 355) (plus y 315)))
      ((equal rel "boundary_R1_inside_R2")
       (srd_region_rect r1 (strcat case_id "_R1_CSET") (plus x 300) (plus y 245) (plus x 355) (plus y 315))
       (srd_region_rect r2 (strcat case_id "_R2_CSET") (plus x 292) (plus y 250) (plus x 340) (plus y 315)))
      ((equal rel "nested_inside")
       (srd_region_rect r2 (strcat case_id "_R2_CSET") (plus x 260) (plus y 220) (plus x 390) (plus y 360))
       (srd_region_rect r1 (strcat case_id "_R1_CSET") (plus x 292) (plus y 250) (plus x 340) (plus y 315)))
      ((equal rel "outer_only")
       (srd_region_rect r2 (strcat case_id "_R2_CSET") (plus x 260) (plus y 220) (plus x 390) (plus y 360))
       (srd_region_rect r1 (strcat case_id "_R1_CSET") (plus x 318) (plus y 250) (plus x 360) (plus y 315)))
      ((equal rel "nested_boundary")
       (srd_region_rect r2 (strcat case_id "_R2_CSET") (plus x 260) (plus y 220) (plus x 390) (plus y 360))
       (srd_region_rect r1 (strcat case_id "_R1_CSET") (plus x 300) (plus y 250) (plus x 350) (plus y 315)))
      ((equal rel "nested_three")
       (srd_create_spacing_cset (strcat case_id "_R3_CSET") 23.0)
       (srd_region_rect r3 (strcat case_id "_R3_CSET") (plus x 245) (plus y 205) (plus x 405) (plus y 375))
       (srd_region_rect r2 (strcat case_id "_R2_CSET") (plus x 260) (plus y 220) (plus x 390) (plus y 360))
       (srd_region_rect r1 (strcat case_id "_R1_CSET") (plus x 292) (plus y 250) (plus x 340) (plus y 315)))
      (t
       (srd_region_rect r1 (strcat case_id "_R1_CSET") (plus x 295) (plus y 250) (plus x 340) (plus y 315)))
    )
  )
)

(defun srd_make_case (idx case_id group rel r1_value r2_value expected question)
  (let ((col nil) (row nil) (x nil) (y nil))
    (setq col (mod idx 6))
    (setq row (quotient idx 6))
    (setq x (plus 250 (times col 750)))
    (setq y (plus 250 (times row 520)))
    ; main static shape and line. Clearance is intentionally below default/R1/R2.
    (srd_rect (plus x 300) (plus y 220) (plus x 420) (plus y 340) "ETCH/TOP" t "SRD_SHAPE")
    ; A small SRD_LINE copper island touches the cline start so Allegro keeps the cline on SRD_LINE.
    (srd_rect (plus x 284) (plus y 180) (plus x 295) (plus y 210) "ETCH/TOP" t "SRD_LINE")
    (srd_path (plus x 289.5) (plus y 210) (plus x 289.5) (plus y 350) 1.0 "ETCH/TOP" "SRD_LINE")
    (srd_case_regions case_id rel x y r1_value r2_value)
    (srd_text (strcat case_id " " group) x (plus y 420))
    (srd_text (strcat "rel=" rel) x (plus y 395))
    (srd_text (strcat "expect=" expected) x (plus y 370))
    (srd_text question x (plus y 30))
  )
)

(defun srd_generate ()
  (fprintf srdLog "enter srd_generate\n")
  (printf "SRD: generating shape-region cases\n")
  (fprintf srdLog "using already-open template\n")
  (srd_create_net_and_classes)
  (fprintf srdLog "after nets\n")
  (srd_create_spacing_cset "DEFAULT" 11.0)
  (axlCNSSpacingModeSet 'all 'off)
  (axlCNSSpacingModeSet 'line_shape 'on)
  (srd_rect 100 100 4700 4300 "BOARD GEOMETRY/OUTLINE" nil nil)
  (srd_text "Shape Region DRC result board: each tile lists relation and expected result" 120 4450)
  (srd_make_case 0 "SR015" "G1" "on_edge" 21.0 22.0 "R1 21" "edge boundary")
  (srd_make_case 1 "SR016" "G1" "outside" 21.0 22.0 "DEFAULT 11" "epsilon outside")
  (srd_make_case 2 "SR017" "G1" "inside" 21.0 22.0 "R1 21" "epsilon inside")
  (srd_make_case 3 "SR018" "G1" "on_vertex" 21.0 22.0 "R1 21" "vertex no cross")
  (srd_make_case 4 "SR019" "G1" "line_inside_shape_outside" 21.0 22.0 "DEFAULT 11" "line marker inside")
  (srd_make_case 5 "SR020" "G1" "shape_inside_line_outside" 21.0 22.0 "R1 21" "shape point inside")
  (srd_make_case 6 "SR021" "G2" "inside" 21.0 22.0 "R1 21" "straight edge")
  (srd_make_case 7 "SR022" "G2" "outside" 21.0 22.0 "DEFAULT 11" "straight outside")
  (srd_make_case 8 "SR023" "G2" "inside" 21.0 22.0 "R1 21" "arc placeholder")
  (srd_make_case 9 "SR024" "G2" "outside" 21.0 22.0 "DEFAULT 11" "arc outside placeholder")
  (srd_make_case 10 "SR025" "G2" "inside" 21.0 22.0 "R1 21" "concave placeholder")
  (srd_make_case 11 "SR026" "G2" "outside" 21.0 22.0 "DEFAULT 11" "concave outside")
  (srd_make_case 12 "SR027" "G3" "outside" 21.0 22.0 "DEFAULT 11" "overall cross ref outside")
  (srd_make_case 13 "SR028" "G3" "inside" 21.0 22.0 "R1 21" "no cross ref inside")
  (srd_make_case 14 "SR029" "G3" "outside" 21.0 22.0 "DEFAULT 11" "mostly inside")
  (srd_make_case 15 "SR030" "G3" "inside" 21.0 22.0 "R1 21" "mostly outside")
  (srd_make_case 16 "SR031" "G4" "upper_band" 21.0 22.0 "UNKNOWN" "upper band covered")
  (srd_make_case 17 "SR032" "G4" "lower_band" 21.0 22.0 "UNKNOWN" "lower band covered")
  (srd_make_case 18 "SR033" "G4" "middle_band" 21.0 22.0 "UNKNOWN" "middle band")
  (srd_make_case 19 "SR034" "G4" "upper_band" 21.0 22.0 "SAME sr031" "line reversed")
  (srd_make_case 20 "SR035" "G4" "upper_band" 21.0 22.0 "SAME sr031" "shape order")
  (srd_make_case 21 "SR036" "G4" "middle_band" 21.0 22.0 "UNKNOWN" "split minima")
  (srd_make_case 22 "SR037" "G4" "inside" 21.0 22.0 "R1 21" "unique min inside")
  (srd_make_case 23 "SR038" "G4" "outside" 21.0 22.0 "DEFAULT 11" "unique min outside")
  (srd_make_case 24 "SR039" "G5" "inside_both" 22.0 21.0 "R1 22" "overlap R1 stricter")
  (srd_make_case 25 "SR040" "G5" "inside_both" 21.0 22.0 "R2 22" "overlap R2 stricter")
  (srd_make_case 26 "SR041" "G5" "touch_edge" 21.0 22.0 "R2 22" "shared edge")
  (srd_make_case 27 "SR042" "G5" "touch_vertex" 21.0 22.0 "R2 22" "shared vertex")
  (srd_make_case 28 "SR043" "G5" "inside_R1_boundary_R2" 21.0 22.0 "UNKNOWN" "inside vs boundary")
  (srd_make_case 29 "SR044" "G5" "boundary_R1_inside_R2" 22.0 21.0 "UNKNOWN" "boundary vs inside")
  (srd_make_case 30 "SR045" "G5" "inside_both" 21.0 22.0 "R2 22" "creation order A")
  (srd_make_case 31 "SR046" "G5" "inside_both" 21.0 22.0 "R2 22" "creation order B")
  (srd_make_case 32 "SR047" "G6" "nested_inside" 21.0 22.0 "R1 inner 21" "inner less strict")
  (srd_make_case 33 "SR048" "G6" "nested_inside" 22.0 21.0 "R1 inner 22" "inner stricter")
  (srd_make_case 34 "SR049" "G6" "outer_only" 21.0 22.0 "R2 outer 22" "outer only")
  (srd_make_case 35 "SR050" "G6" "nested_boundary" 21.0 22.0 "R1 inner 21" "inner boundary")
  (srd_make_case 36 "SR051" "G6" "nested_boundary" 21.0 22.0 "UNKNOWN" "touching nested")
  (srd_make_case 37 "SR052" "G6" "nested_three" 21.0 22.0 "R1 inner 21" "three level")
  (srd_make_case 38 "SR053" "G6" "nested_three" 21.0 22.0 "UNKNOWN" "complex nested")
  (srd_make_case 39 "SR054" "G7" "inside" 21.0 22.0 "R1 21" "one DBU inside")
  (srd_make_case 40 "SR055" "G7" "on_edge" 21.0 22.0 "R1 21" "exact boundary")
  (srd_make_case 41 "SR056" "G7" "outside" 21.0 22.0 "DEFAULT 11" "one DBU outside")
  (srd_make_case 42 "SR057" "G7" "on_edge" 21.0 22.0 "UNKNOWN" "arc tangent")
  (axlSaveDesign ?design "out/shape_region_result_cases.brd" ?mode "nocheck" ?noConfirm t)
  (printf "SRD: saved out/shape_region_result_cases.brd\n")
  (fprintf srdLog "saved result board\n")
  (close srdLog)
  (axlOSExit 0)
)

(srd_generate)
